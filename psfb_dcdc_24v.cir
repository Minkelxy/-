*============================================
* Phase-Shifted Full Bridge DC-DC Converter
* Input: 24VDC  Output: 12VDC @ 10A
*============================================

* Power Supply
V_in Vin 0 DC 24

*----- Primary Side -----
* Leading Leg Switches using ideal switches
S_Lead_H Vin G1 Switch1 0 SW
S_Lead_L Switch1 G3 0 0 SW

* Lagging Leg Switches - Phase Shifted
S_Lag_H Vin G2 Switch2 0 SW
S_Lag_L Switch2 G4 0 0 SW

.MODEL SW SW (Ron=10m Roff=10Meg Vt=5)

* Resonant Inductor
Lr Switch1 Switch2 12uH

* Transformer
Lp Switch1 P_node 60uH
Ls S_node Out_P 60uH
K_tr Lp Ls 0.998

*----- Secondary Side -----
* Diodes for rectification
D1 Out_P S_node DSchottky
D2 S_node Out_N DSchottky

* Diode Models (Standard LTspice Diode)
.MODEL DSchottky D (Is=1e-4 Rs=0.05 n=1.5)

* Output Filter
Lf Out_P Load_P 40uH
Cout Load_P Load_N 470u
Rload Load_P Load_N 1.2

*----- Gate Drives -----
* 100kHz period = 10us
* Q1, Q3: 0-4.5us = ON (leading)
* Q2, Q4: 2.5-7us = ON (lagging, 90deg phase shift)

Vg1 G1 0 PULSE(0 15 0n 10n 10n 4.5u 10u)
Vg3 G3 0 PULSE(15 0 0n 10n 10n 4.5u 10u)

Vg2 G2 0 PULSE(0 15 2.5u 10n 10n 4.5u 10u)
Vg4 G4 0 PULSE(15 0 2.5u 10n 10n 4.5u 10u)

*----- Measurements -----
.MEAS TRAN Voutput AVG V(Load_P,Load_N)
.MEAS TRAN Ioutput AVG I(Rload)

*----- Simulation Control -----
.TRAN 0 40m 0 50n STARTUP

.END
